//-----------------------------------------------------------------------------
// tb_afe_receiver.va - stimulus and checker for afe_receiver
//                      (netlist: tb_afe_receiver.scs)
//
// Drives RX_IN_P / RX_IN_N as an ideal differential source around a 200 mV
// common mode: vd = ramp (slow, for thresholds; static, for the disconnect
// test) + amp * alternating J/K at 480 Mbit/s with 625 ps edges (the worst
// case for the squelch envelope: a zero crossing every bit).
//
// Sequence
//    1  ramp -50 -> +50 -> -50 mV over 1 us     RX_OUT_P switches at +10 / -10 mV
//                                               (hysteresis 20 mV), squelched
//    3  400 mV pattern starts                   SQUELCH_A falls 4 ns later
//                                               (+ output stage); RX_OUT_P
//                                               delay 0.3 ns; DISC_A stays 0
//    4  pattern stops                           SQUELCH_A rises 12 ns later
//    5  90 mV pattern                           never released (< 100 mV)
//    6  160 mV pattern                          released (> 150 mV)
//    8  2 ns burst at 400 mV                    ignored (shorter than
//                                               t_sq_on - t_bridge = 3 ns)
//   10  static 500 mV                           DISC_A = 0
//   11  static 650 mV                           DISC_A = 1 after 4 ns
//   12  RX_EN = 0, then RX_VDD = 2.5 V           isolated outputs: RX_OUT_P = 0,
//                                               RX_OUT_N = 1, SQUELCH_A = 1, DISC_A = 0
// The disconnect detector needs a level held longer than t_disc (the HS EOP,
// 8 bits): an alternating pattern dips below the threshold every bit.
//-----------------------------------------------------------------------------
`include "constants.vams"
`include "disciplines.vams"
`include "tb_afe_common.vams"

module tb_afe_receiver_chk (RX_IN_P, RX_IN_N, RX_EN, RX_VREF, RX_OUT_P, RX_OUT_N,
                            SQUELCH_A, DISC_A, RX_VDD, RX_VDDO, GND);
    output     RX_IN_P, RX_IN_N, RX_EN, RX_VREF;
    input      RX_OUT_P, RX_OUT_N, SQUELCH_A, DISC_A;
    inout      RX_VDD, RX_VDDO, GND;
    electrical RX_IN_P, RX_IN_N, RX_EN, RX_VREF, RX_OUT_P, RX_OUT_N, SQUELCH_A, DISC_A,
               RX_VDD, RX_VDDO, GND;

    parameter real ui     = 2.0833333e-9;
    parameter real v_hys  = 20e-3;      // DUT defaults
    parameter real t_dly  = 0.3e-9;
    parameter real t_on   = 4e-9;
    parameter real t_off  = 12e-9;
    parameter real t_disc = 4e-9;
    parameter real t_out  = 0.125e-9;   // squelch / disc output stage: t_dly + t_rf / 2
    parameter real v_tol  = 0.5e-3;     // switching-threshold tolerance
    parameter real t_tol  = 0.0;        // widens every timing window by +-t_tol
                                        // (transistor netlist: tb_afe_receiver_tr.scs)

    real    t_step, dt, vr, t_r, amp, vdd, vdiff, vsw_up, vsw_dn;
    real    t_set, t_sqf, t_sqr, t_dr, t_vdr, d_out;
    integer errors, reported, step, arm, sgn, en, n_sqf;

    analog begin
        @(initial_step) begin
            errors = 0; reported = 0; step = 0; t_step = 0.0; arm = 0;
            vr = -0.05; t_r = 1e-6; amp = 0.0; vdd = 3.3; sgn = 1; en = 1; n_sqf = 0;
            vsw_up = 1.0; vsw_dn = 1.0; t_set = 0; t_sqf = 0; t_sqr = 0; t_dr = 0; t_vdr = 0; d_out = 0;
        end

        // ---- stimulus ----
        @(timer(0, ui)) sgn = -sgn;
        vdiff = transition(vr, 0, t_r) + transition(amp, 0, 100e-12) * transition(sgn, 0, 625e-12);
        V(RX_IN_P, GND) <+ 0.2 + 0.5 * vdiff;
        V(RX_IN_N, GND) <+ 0.2 - 0.5 * vdiff;
        V(RX_EN, GND)   <+ 1.8 * transition(en, 0, 50e-12);
        V(RX_VREF, GND) <+ 1.2;
        V(RX_VDD, GND)  <+ transition(vdd, 0, 1e-9);
        V(RX_VDDO, GND) <+ 1.8;

        // ---- captures ----
        @(cross(V(RX_OUT_P, GND) - 0.9, +1)) begin
            if (arm == 1) vsw_up = V(RX_IN_P, RX_IN_N);
            if (arm == 2) d_out = $abstime - t_vdr;     // vd zero crossing -> output
        end
        @(cross(V(RX_OUT_P, GND) - 0.9, -1)) if (arm == 1) vsw_dn = V(RX_IN_P, RX_IN_N);
        @(cross(V(RX_IN_P, RX_IN_N), +1))    if (arm == 2) t_vdr = $abstime;
        @(cross(V(SQUELCH_A, GND) - 0.9, -1)) begin t_sqf = $abstime; n_sqf = n_sqf + 1; end
        @(cross(V(SQUELCH_A, GND) - 0.9, +1)) t_sqr = $abstime;
        @(cross(V(DISC_A, GND) - 0.9, +1))    t_dr = $abstime;

        // ---- sequence ----
        @(timer(t_step)) begin
            case (step)
                0: dt = 50e-9;
                1: begin
                    `TB_RNG("-50 mV: RX_OUT_P [V]", V(RX_OUT_P, GND), -0.01, 0.1)
                    `TB_RNG("-50 mV: RX_OUT_N [V]", V(RX_OUT_N, GND), 1.7, 1.81)
                    `TB_RNG("-50 mV: SQUELCH_A [V]", V(SQUELCH_A, GND), 1.7, 1.81)
                    arm = 1; vr = 0.05;
                    dt = 1.1e-6;
                end
                2: begin
                    `TB_RNG("+50 mV: RX_OUT_P [V]", V(RX_OUT_P, GND), 1.7, 1.81)
                    `TB_RNG("upper switching threshold [V]", vsw_up, 0.5 * v_hys - v_tol, 0.5 * v_hys + v_tol)
                    vr = -0.05;
                    dt = 1.1e-6;
                end
                3: begin
                    `TB_RNG("-50 mV again: RX_OUT_P [V]", V(RX_OUT_P, GND), -0.01, 0.1)
                    `TB_RNG("lower switching threshold [V]", vsw_dn, -0.5 * v_hys - v_tol, -0.5 * v_hys + v_tol)
                    arm = 2; vr = 0.0; t_r = 100e-12;
                    amp = 0.4; t_set = $abstime; n_sqf = 0;          // HS traffic
                    dt = 30e-9;
                end
                4: begin
                    `TB_RNG("400 mV: SQUELCH_A [V]", V(SQUELCH_A, GND), -0.01, 0.1)
                    `TB_RNG("squelch release after the line became active [s]", t_sqf - t_set,
                            t_on + t_out - 0.05e-9 - t_tol, t_on + t_out + 0.6e-9 + t_tol)
                    `TB_RNG("RX_OUT_P delay after DP - DM = 0 [s]", d_out, t_dly - t_tol, t_dly + 0.06e-9 + t_tol)
                    `TB_RNG("400 mV alternating: DISC_A [V]", V(DISC_A, GND), -0.01, 0.1)
                    arm = 0; amp = 0.0; t_set = $abstime;            // line idle
                    dt = 30e-9;
                end
                5: begin
                    `TB_RNG("idle: SQUELCH_A [V]", V(SQUELCH_A, GND), 1.7, 1.81)
                    `TB_RNG("squelch assertion after the line went idle [s]", t_sqr - t_set,
                            t_off + t_out - 0.25e-9 - t_tol, t_off + t_out + 0.3e-9 + t_tol)
                    amp = 0.09; n_sqf = 0;
                    dt = 50e-9;
                end
                6: begin
                    `TB_CHK(n_sqf == 0, "squelch released by a 90 mV signal")
                    amp = 0.16;
                    dt = 30e-9;
                end
                7: begin
                    `TB_RNG("160 mV: SQUELCH_A [V]", V(SQUELCH_A, GND), -0.01, 0.1)
                    amp = 0.0;
                    dt = 30e-9;
                end
                8: begin
                    n_sqf = 0; amp = 0.4;                            // short burst
                    dt = 2e-9;
                end
                9: begin
                    amp = 0.0;
                    dt = 30e-9;
                end
                10: begin
                    `TB_CHK(n_sqf == 0, "squelch released by a 2 ns burst")
                    vr = 0.5;                                        // static 500 mV
                    dt = 30e-9;
                end
                11: begin
                    `TB_RNG("static 500 mV: DISC_A [V]", V(DISC_A, GND), -0.01, 0.1)
                    vr = 0.65; t_set = $abstime;
                    dt = 30e-9;
                end
                12: begin
                    `TB_RNG("static 650 mV: DISC_A [V]", V(DISC_A, GND), 1.7, 1.81)
                    `TB_RNG("DISC_A delay [s]", t_dr - t_set, t_disc + t_out - t_tol, t_disc + t_out + 0.2e-9 + t_tol)
                    en = 0;
                    dt = 20e-9;
                end
                13: begin
                    `TB_RNG("RX_EN = 0: RX_OUT_P [V]", V(RX_OUT_P, GND), -0.01, 0.1)
                    `TB_RNG("RX_EN = 0: RX_OUT_N [V]", V(RX_OUT_N, GND), 1.7, 1.81)
                    `TB_RNG("RX_EN = 0: SQUELCH_A [V]", V(SQUELCH_A, GND), 1.7, 1.81)
                    `TB_RNG("RX_EN = 0: DISC_A [V]", V(DISC_A, GND), -0.01, 0.1)
                    en = 1; vdd = 2.5;
                    dt = 20e-9;
                end
                14: begin
                    `TB_RNG("RX_VDD = 2.5 V: RX_OUT_P [V]", V(RX_OUT_P, GND), -0.01, 0.1)
                    `TB_RNG("RX_VDD = 2.5 V: SQUELCH_A [V]", V(SQUELCH_A, GND), 1.7, 1.81)
                    `TB_RNG("RX_VDD = 2.5 V: DISC_A [V]", V(DISC_A, GND), -0.01, 0.1)
                    `TB_FINISH
                    $finish;
                end
            endcase
            step = step + 1;
            t_step = $abstime + dt;
        end

        @(final_step) begin
            `TB_TIMEOUT
        end
    end
endmodule
